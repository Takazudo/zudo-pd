* m12_light_19 TPS54560 average-model loop gain, inverting buck-boost (vendor SLVMCU2 AVG.LIB)
* Simulator ground is the IC GND (M12_RAW); node sg is the system ground, so the
* model's absolute COMP reference stays at the IC GND as in the buck case.
.include ../lib/tps54560_avg.lib
VIN vin sg 19
XU comp 0 sw vin fb TPS54560_AVG PARAMS: L=10u FS=557k
L1 sw ll 10u
RL1 ll sg 68m
CI1 vin 0 11u
CO sg rco 2.2032e-05
RCO rco 0 0.00075
RFT sg fbd 145k
RFB fbd 0 10k
Vinj fb fbd DC 0 AC 1
RJ fbd vj 4.7meg
VJ vj 0 0.8
RCP comp cz 8.2k
CCP cz 0 47n
CHF comp 0 150p
LF 0 prel 10u
RLF prel pre 68m
CF1 sg cf1 47u
RCF1 cf1 pre 30m
CF2 sg cf2 5.508u
RCF2 cf2 pre 3m
RLOAD sg pre 242.6
.nodeset v(sg)=12.2 v(pre)=0 v(vin)=31.2 v(comp)=0.6 v(fb)=0.8 v(fbd)=0.8
.control
op
print v(sg) v(pre) v(comp)
ac dec 50 100 1meg
let t = -v(fbd)/v(fb)
wrdata m12_light_19_47n.dat t
.endc
.end
